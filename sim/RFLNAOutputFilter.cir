* RF LNA out filter from the LNA to the splitter

.include ImpedanceMatchers.cir
.include Filters.cir

.param m = 0

* Measure the full filter chain loss.
.if (m == 1)
Vin in1 0 dc 0 AC 1 sin(0 1 146MEG 0 0 0)
X0 in1 in in2 in3 LNAOutImpedance
* Used for current measurement.
Vmin in in2 dc 0 ac 0
X1 in3  a1 ImpMatchLNAOut
X2 a1 out1 Filt144MHzLNAOut
* Used for current measurement.
Vmout out1 out DC 0 AC 0
Rload out 0    50
.endif

* Measure the input impedance
.if (m == 2)
I1 0    in  dc 0 ac 1
X1 in out Filt144MHzLNAOut
Rout out 0 50
.endif

* Now the output impedance
.if (m == 3)
I1 0  out  dc 0 ac 1
X1 in out Filt144MHzLNAOut
Rin in 0 50
.endif

* Now just the filter
.if (m == 4)
Vin ina 0 dc 0 AC 1 sin(0 1 146MEG 0 0 0)
Rsrc ina in 50
* Used for current measurement.
Vmin in in1 AC 0 DC 0
X1 in1 out Filt144MHzLNAOut
* Used for current measurement.
Vmout out out2 DC 0 AC 0
Rload out2 0    50
.endif

* Input impedance of the L match
.if (m == 5)
I1  0  in  dc 0 ac 1
X1 in out ImpMatchLNAOut
X0 out x1 x1 0 LNAOutImpedance
.endif

* Measure the full chain input impedance
.if (m == 6)
I1  0  in  dc 0 ac 1
X1 in a1 Filt144MHzLNAOut
X2 a1 out ImpMatchLNAOut
X3 out x1 x1 0 LNAOutImpedance
.endif

.control
*tran 1ns 102000ns 101000ns
*plot v(in1), v(out)

alterparam m = 1
reset
ac lin 50000 1Meg 500Meg
plot title "Full Chain Filter Loss" db((v(out) * i(Vmout)) / (vm(in) * i(Vmin)))

alterparam m = 2
reset
ac lin 50000 3Meg 500Meg
plot title "Filter Only Input Impedance" v(in) vi(in)

alterparam m = 3
reset
ac lin 50000 3Meg 500Meg
plot title "Filter Only Output Impedance" v(out) vi(out)

alterparam m = 4
reset
ac lin 50000 3Meg 500Meg
plot title "Filter Loss" db((v(out) * i(Vmout)) / (v(in) * i(Vmin)))
*plot vr(out) vi(out) vp(out)

alterparam m = 5
reset
ac lin 50000 100Meg 500Meg
plot title "L Match Input Impedance" v(in) vi(in)

alterparam m = 6
reset
ac lin 50000 100Meg 500Meg
plot title "Full Chain Input Impedance" v(in) vi(in)

.endc

.end
