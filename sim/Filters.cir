* Various filters in the PacSat board

* Unless otherwise mentioned, assume all inductors have a Q of around 35
* at 144MHz.  This is a pretty good assumption for the Coilcraft 0603DC
* inductors.

* Unless otherwise mentioned, assume all inductors have a Q of around 55
* at 435MHz.  This is a pretty good assumption for the Coilcraft 0402DC
* inductors.

* Comments above are the exact values from the generation tool.
* Value used are available inductors and capacitors.

*                   input
*                   |   output
*                   |   |
.SUBCKT Filt440MHz in  out

* 480MHz Elliptic lowpass filter, simulated from:
* https://markimicrowave.com/technical-resources/tools/lc-filter-design-tool/
* 5th order, shunt first, 480MHz cutoff, .10db ripple in passband, 50
* ohm input, 50 ohm output impedance, 50dB stopband attenuation.
*

* I looked at using a 3rd order or 4th order filter, but 3rd order
* only supplies -11dB at the first harmonic.  4th order was -22dB.
* The 5th order filter here is -50dB at the first harmonic of 435MHz.

* 7.01p
* Use a 6.4p cap, add .4p for parasitics
C1	in	0	6.8p

* 20.8n
* Coilcraft 0402DC-20NX_RW Q=48@435MHz SRF=5.11
* Add .4nH for parasitics
L2	in	a1	20.4n
Rl2	a1	a2	0.99
Cl2	in	a2	.048p
* 735f
* .75pF, add .25 for parasitics
C2	in	a2	1.0p

* 11.35p
* Use a 11p cap, add .4p for parasitics
C3	a2	0	11p

* 17.22n
* Murata LQW15AN17NG8ZD 17nF, Q=46@439MHz, SRF=5G
* Add .4nH for parasitics
L4	a2	a3	17.4n
Rl4	a3	out	1.01
Cl4	a2	out	.059p
* 2.07p
* 2.0p, add .2p for parasitics
C4	a2	out	2.2p

* 5.94p
* Use a 5.4p cap, add .4p for parasitics
C5	out	0	5.8p

* This is the inductor used to bleed off static from the antenna
L0	out	b0	470n
R0	b0	0	12

.if (0)
* This is a 3rd-order Chebyshev followed by a 3rd order elliptic.
* It performs very similar to the above filter.  Not quite as much
* stop band, though.  Interesting experiment.
C1	in	0	6.8p

L2	in	a1	19n
Rl2	a1	a2	1.13
Cl2	in	a2	.048p
* 735f
C2	in	a2	1.0p

C3a	a2	0	6.8p

C3b	a2	0	6.7p

L4	a2	a3	18.5n
Rl4	a3	out	1.01
Cl4	a2	out	.059p
C4	a2	out	1.18p

C5	out	0	6.7p
.endif

.ENDS

*                       input
*                       |   output
*                       |   |
.SUBCKT Filt144MHzLNAIn in  out

* 176MHz Elliptic lowpass filter, shunt first, with 50dB stopband
* attenuation and 1dB ripple in the passband.  50ohm input and output.

* This is the inductor used to bleed off static from the antenna
L0	in	b0	470n
R0	b0	0	10k

* 38.0
C1	in	0	36p

* 1.28p
C2	in	out	1p
* 45.9n
* Coilcrage 0805CS, Q=55 at 150MHz
L1	in	b1	47n
Rl1	b1	out	0.78
Cl1	in	out	.186p

C3	out	0	36p

.if (0)
* 123-173MHz Chebychev bandpass filter, simulated from:
* https://markimicrowave.com/technical-resources/tools/lc-filter-design-tool/
* 3rd order, conventional shunt first, 123MHz low cutoff, 173MHz high
* cutoff, .10db ripple in passband, 50 ohm input, 50 ohm output
* impedance.

* 65.57p
C1	in	0	68p
* 18.13n
L1	in	b1	18n
R1      b1	0	.5

* 6.519p
C2	in	a1	6.5p
* 182.6
* Coilcraft 0805CS, Q of around 55 at 150MHz
L2	a1	a2	180n
R2	a2	out	3.00

C3	out	0	68p
L3	out	b2	18n
R3      b2	0	.5
.endif

.ENDS

*                        input
*                        |   output
*                        |   |
.SUBCKT Filt144MHzLNAOut in  out

.if (1)
* 123-173MHz Chebychev bandpass filter, simulated from:
* https://markimicrowave.com/technical-resources/tools/lc-filter-design-tool/
* 3rd order, conventional shunt first, 123MHz low cutoff, 173MHz high
* cutoff, .10db ripple in passband, 50 ohm input, 50 ohm output
* impedance.

* 65.57p
C1	in	0	68p
* 18.13n
L1	in	b1	18n
R1      b1	0	.33

* 6.519p
C2	in	a1	6.5p
* 182.6
* CoilCraft 0805CS, Q=55 at 150MHz
L2	a1	a2	180n
R2	a2	out	3.00

C3	out	0	68p
L3	out	b2	18n
R3      b2	0	.33

.endif

.if (0)
* 140-150MHz Elliptic bandpass filter, simulated from:
* https://markimicrowave.com/technical-resources/tools/lc-filter-design-tool/
* 3rd order, conventional shunt first, 140 low cutoff, 150 high
* cutoff, .10db ripple in passband, 50 ohm input, 50 ohm output
* impedance, 50.42dB stopband attenuation

* Note that almost all of the loss is in R1 and R4.  R2 and R3 make
* very little contribution to the loss.  If inductors could be found
* that have lower series resistance it would greatly improve the loss
* in the filter.  Using two larger inductors in parallel results in
* lowering the series resistance from 46m to 26.5m, making about 2dB
* improvement.

* 322.4p
C1	in	0	320p
* 3.742n * 2% Q=68 0402DC-3N7XGRW
L1	in	b1	3.7n
R1	b1	0	.1
* 7.5n 2% Q=88 0603DC-7N5XGRW
*L1a	in	b1a	7.5n
*R1a	b1a	0	.2
*L1b	in	b1b	7.5n
*R1b	b1b	0	.2

* 13.25p
C2	in	a1	13p
* 60.45n * 62n 2% Q=70 LQW2BAN62NG00L 0805
L2	in	a2	62n
R2	a2	a1	.120

* 19.95p
C3	a1	out	20p
* 91.06n * 91n 2% Q=70 LQW2BAN91NG00L 0805
L3	a1	a4	91n
R3	a4	out	.210

* Same as first values above.
C4	out	0	320p
L4	out	b2	3.7n
R4	b2	0	.1
*L4a	out	b2a	7.5n
*R4a	b2a	0	.2
*L4b	out	b2b	7.5n
*R4b	b2b	0	.2
.endif

.if (0)
* This is a 3rd order Chebychev bandpass filter direct coupled, shunt
* capacitor, 140 to 150MHz .1dB ripple in the passband, 50 ohms input
* and output impedance.  The direct coupled inductor is 91nH.
*
* This has slightly less loss than the Elliptic filter, but not as
* good performance.  The nice thing is you pick a single inductor
* value, so dealing with the inductor isn't so hard.  Performance
* is more important than loss at this point.

*
C1	in	0	62.13p
*
C2	in	a1	17.69p
*
L1	a1	a2	91n
R1	a2	a3	.210
*
C3	a3	0	208.7p
*
C4	a3	a4	15.14p
*
L2	a4	a5	91n
R2	a5	a6	.210
*
C5	a6	0	208.7p
*
C6	a6	a7	17.69p
*
L3	a7	a8	91n
R3	a8	out	.210
*
C7	out	0	62.13p
.endif

.ENDS
