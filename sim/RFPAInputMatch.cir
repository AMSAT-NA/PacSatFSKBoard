* Simulations of the PA input matcher

.include ImpedanceMatchers.cir

.param measimp = 0

.if (measimp == 0)
Rsrc in1 in  50
X1 in2 a1 ImpMatchPAIn
X2 a1 out out2 0 PAInImpedance

V1 in1 0 dc 0 AC 1 sin(1 0 435MEG 0 0 0)

* For current measurement
Vmin  in  in2  dc 0 ac 0

* For current measurement
Vmout out out2 dc 0 ac 0
.endif

.if (measimp == 1)
I1 0 in dc 0 ac 1
X1 in a1 ImpMatchPAIn
X2 a1 x1 x1 0 PAInImpedance
.endif

.control

alterparam measimp = 0
reset
ac lin 5000 1Meg 1000meg
plot title "PA Input Match Loss" db((v(out) * i(Vmout)) / (v(in) * i(Vmin)))

alterparam measimp = 1
reset
ac lin 5000 400Meg 500meg
plot title "PA Input Match Impedance" v(in) vi(in)
.endc
