* RF input filter from the antenna to the LNA

* Unless otherwise mentioned, assume all inductors have a Q of around 35
* at 144MHz.  This is a pretty good assumption for the Coilcraft 0603DC
* inductors.

.include ImpedanceMatchers.cir
.include Filters.cir

.param m = 0

* Full chain loss
.if (m == 1)
V1 0 in dc 0 AC 1 sin(0 1 146MEG 0 0 0)
Rsrc in in1 50

X1 in1 a1   Filt144MHzLNAIn
X2 a1  out1 ImpMatchLNAIn

*.model tline50_TX ltra rel=1 r=.01 g=0
*+ l=2.62e-10 c=1.05e-13 len=100
*OTX in1 0 n1 0 tline50_TX
*X3 n1 b1 Filt440MHz
*Rm b1 0 50

X3 out1 out out2 0 LNAInImpedance

* Used for current measurement.
Vmout out out2 DC 0 AC 0
.endif

* Measure the filter input impedance
.if (m == 2)
I1  0  in  dc 0 ac 1
X1 in out Filt144MHzLNAIn
Rout out 0 50
.endif

* Now the filter output impedance
.if (m == 3)
I1  0  out  dc 0 ac 1
X1 in out Filt144MHzLNAIn
Rin in 0 50
.endif

* Now filter loss
.if (m == 4)
Vin ina 0 dc 0 AC 1 sin(0 1 146MEG 0 0 0)
Rsrc ina in 50
* Used for current measurement.
Vmin in a1 AC 0 DC 0
X1 a1 out Filt144MHzLNAIn
* Used for current measurement.
Vmout out out2 DC 0 AC 0
Rload out2 0    50
.endif

* Input impedance of the L match
.if (m == 5)
I1  0  in  dc 0 ac 1
X1 in out ImpMatchLNAIn
X0 out x1 x1 0 LNAInImpedance
.endif

* Measure the full chain input impedance
.if (m == 6)
I1  0  in  dc 0 ac 1
X1 in a1 Filt144MHzLNAIn
X2 a1 out ImpMatchLNAIn
X3 out x1 x1 0 LNAInImpedance
.endif

.control
*tran 1ns 102000ns 101000ns
*plot v(in1), v(out)

alterparam m = 1
reset
ac lin 50000 1Meg 500Meg
plot title "Full Chain Filter Loss" db((v(out) * i(Vmout)) / (vm(in1) * i(V1)))

alterparam m = 2
reset
ac lin 50000 3Meg 1000Meg
plot title "Filter Only Input Impedance" v(in) vi(in)

alterparam m = 3
reset
ac lin 50000 3Meg 1000Meg
plot title "Filter Only Output Impedance" v(out) vi(out)

alterparam m = 4
reset
ac lin 50000 3Meg 1000Meg
plot title "Filter Only Loss" db((v(out) * i(Vmout)) / (v(in) * i(Vmin)))
*plot vr(out) vi(out) vp(out)

alterparam m = 5
reset
ac lin 50000 100Meg 500Meg
plot title "L Match Input Impedance" v(in) vi(in)

alterparam m = 6
reset
ac lin 50000 100Meg 500Meg
plot title "Full Chain Input Impedance" v(in) vi(in)

.endc

.end
