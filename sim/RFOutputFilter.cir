* Impedance matching network and output filter from the PA

.include ImpedanceMatchers.cir
.include Filters.cir

.param m = 0

* Full chain loss
.if (m == 1)
Vin ina 0 dc 0 AC 1 sin(0 1 435MEG 0 0 0)
X0 ina x1 x1 in PAOutImpedance
* Used for current measurement.
Vmin in in1 AC 0 DC 0
X1 in1 a1  ImpMatchPAOut
X2 a1  out Filt440MHz
* Used for current measurement.
Vmout out out2 DC 0 AC 0
Rload out2 0    50
.endif

* Measure the input impedance of the filter
.if (m == 2)
I1  0  in  dc 0 ac 1
X1 in out Filt440MHz
Rout out 0 50
.endif

* Now the output impedance of the filter
.if (m == 3)
I1  0  out  dc 0 ac 1
X1 in out Filt440MHz
Rin in 0 50
.endif

* Now the loss in the filter
.if (m == 4)
Vin ina 0 dc 0 AC 1 sin(0 1 435MEG 0 0 0)
Rsrc ina in 50
* Used for current measurement.
Vmin in a1 AC 0 DC 0
X1 a1 out Filt440MHz
* Used for current measurement.
Vmout out out2 DC 0 AC 0
Rload out2 0    50
.endif

* Input impedance of the L match
.if (m == 8)
I1  0  in  dc 0 ac 1
X1 in out ImpMatchPAOut
Rout out 0 50
.endif

* Output impedance of the L match
.if (m == 5)
I1  0  out  dc 0 ac 1
X0 0 x1 x1 a1 PAOutImpedance
X1 a1 out ImpMatchPAOut
.endif

* Loss of the L match
.if (m == 7)
Vin ina 0 dc 0 AC 1 sin(0 1 435MEG 0 0 0)
X0 ina in in1 a1 PAOutImpedance
Vmin in in1 dc 0 ac 0
X1 a1 out ImpMatchPAOut
* Used for current measurement.
Vmout out out2 DC 0 AC 0
Rload out2 0 50
.endif

* Measure the full chain output impedance
.if (m == 6)
I1  0  out  dc 0 ac 1
X0 0 x1 x1 in1 PAOutImpedance
X1 in1 a1 ImpMatchPAOut
X2 a1 out Filt440MHz
.endif

.control
*tran 1ns 102000ns 101000ns
*plot v(in1), v(out)

alterparam m = 1
reset
ac lin 50000 3Meg 1000Meg
* .663 is 2 * sqrt(Zin / Zout) = 2 * sqrt(5.5 / 50)
plot title "Full Chain Filter Loss" db(.663 * v(out) / v(ina))
*plot vr(out) vi(out) vp(out)

alterparam m = 2
reset
ac lin 50000 3Meg 1000Meg
plot title "Filter Only Input Impedance" v(in) vi(in)

alterparam m = 3
reset
ac lin 50000 3Meg 1000Meg
plot title "Filter Only Output Impedance" v(out) vi(out)

alterparam m = 4
reset
ac lin 50000 3Meg 1000Meg
* Since Zin == Zout, 2 * sqrt(Zin / Zout) = 2
plot title "Filter only Loss" db(2 * v(out) / v(ina))

alterparam m = 8
reset
ac lin 50000 100Meg 500Meg
plot title "L Match Input Impedance" v(in) vi(in)

alterparam m = 5
reset
ac lin 50000 100Meg 500Meg
plot title "L Match Output Impedance" v(out) vi(out)

alterparam m = 7
reset
ac lin 50000 3Meg 1000Meg
* .663 is 2 * sqrt(Zin / Zout) = 2 * sqrt(5.5 / 50)
plot title "L Match only Loss" db(.663 * v(out) / v(ina))

alterparam m = 6
reset
ac lin 50000 100Meg 1000Meg
plot title "Full Chain out Impedance" v(out) vi(out)

.endc

.end
