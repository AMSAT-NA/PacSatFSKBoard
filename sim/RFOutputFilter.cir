* Impedance matching network and output filter from the PA

* Unless otherwise mentioned, assume all inductors have a Q of around 55
* at 435MHz.  This is a pretty good assumption for the Coilcraft 0402DC
* inductors.
*                     input
*                     |   output
*                     |   |
.SUBCKT ImpMatchPAOut in  out

* Coilcraft 0402DC-6N0XGRW 6.0nH
C1	in	out	15p
L1	out	a1	5.8n
Rl1	a1	0	.34
Cl1	out	0	.037p
* Impedance matching network

.ENDS

*                   input
*                   |   output
*                   |   |
.SUBCKT Filt440MHz in  out

* 480MHz Elliptic lowpass filter, simulated from:
* https://markimicrowave.com/technical-resources/tools/lc-filter-design-tool/
* 5th order, shunt first, 480MHz cutoff, .10db ripple in passband, 50
* ohm input, 50 ohm output impedance, 50dB stopband attenuation.
*

* I looked at using a 3rd order or 4th order filter, but 3rd order
* only supplies -11dB at the first harmonic.  4th order was -22dB.
* The 5th order filter here is -50dB at the first harmonic of 435MHz.

* 7.01p
* Use a 6.4p cap, add .6p for parasitics
C1	in	0	7.0p

* 20.8n
* Coilcraft 0402DC-20NX_RW Q=48@435MHz SRF=5.11
* Add .4nH for parasitics
L2	in	a1	20.4n
Rl2	a1	a2	1.13
Cl2	in	a2	.048p
* 735f
C2	in	a2	1.0p

* 11.35p
* Use a 11p cap, add .6p for parasitics
C3	a2	0	11.6p

* 17.22n
* Murata LQW15AN17NG8ZD 17nF, Q=46@439MHz, SRF=5G
* Add .4nH for parasitics
L4	a2	a3	17.4n
Rl4	a3	out	1.01
Cl4	a2	out	.059p
* 2.07p
C4	a2	out	2.2p

* 5.94p
* Use a 5.4p cap, add .6p for parasitics
C5	out	0	6.0p

* This is the inductor used to bleed off static from the antenna
L0	out	b0	470n
R0	b0	0	12

.ENDS

.param m = 0

.if (m == 1)
Vin ina 0 dc 0 AC 1 sin(0 1 435MEG 0 0 0)

Csrc ina  ina1 718p
Rsrc ina1 ina2 4.63

* Inductor on the PA output.
Lpa  ina2  0 100n

* Used for current measurement.
Vmin ina2 ina3 AC 0 DC 0

* Trace inductance, see L-match output impedance below for details.
Lp1  ina3  in 3.4n

X1 in  im1 ImpMatchPAOut

X2 im1 out Filt440MHz

* Used for current measurement.
Vmout out out2 DC 0 AC 0

Rload out2 0    50
.endif

* Measure the input impedance
.if (m == 2)

I1  0  in  dc 0 ac 1

X1 in out Filt440MHz

Rout out 0 50

.endif

* Now the output impedance
.if (m == 3)

I1  0  out  dc 0 ac 1

X1 in out Filt440MHz

Rin in 0 50

.endif

* Now just the filter
.if (m == 4)
Vin ina 0 dc 0 AC 1 sin(0 1 435MEG 0 0 0)

Rsrc ina ina1 50

* Used for current measurement.
Vmin ina1 in AC 0 DC 0

X1 in out Filt440MHz

* Used for current measurement.
Vmout out out2 DC 0 AC 0

Rload out2 0    50
.endif

* Output impedance of the L match
.if (m == 5)

Csrc 0  ina1 718p
Rsrc ina1 in 4.63

* Inductor on the PA output.
Lpa  in  0 100n

* 7mm of trace, coplanar .225mm with .5mm spacing, .109mm over ground
* Calculated from https://wcalc.sourceforge.net/cgi-bin/coplanar.cgi
* .31uH/mm, .134pF/mm.  Finagled this a little bit, measurement shows
* a little more inductance than the 2.1 calculated and no capacitance.
Lp1  in  in1 3.4n
*Cp1  in1 0   0.93p

X1 in1 out ImpMatchPAOut

I1  0  out  dc 0 ac 1
.endif

.control
*tran 1ns 102000ns 101000ns
*plot v(in1), v(out)

alterparam m = 1
reset
ac lin 50000 3Meg 1000Meg
plot title "Full Chain Filter Loss" db((v(out) * i(Vmout)) / (v(ina2) * i(Vmin)))
*plot vr(out) vi(out) vp(out)

alterparam m = 2
reset
ac lin 50000 3Meg 1000Meg
plot title "Filter Only Input Impedance" v(in) vi(in)

alterparam m = 3
reset
ac lin 50000 3Meg 1000Meg
plot title "Filter Only Output Impedance" v(out) vi(out)

alterparam m = 4
reset
ac lin 50000 3Meg 1000Meg
plot title "Filter Loss" db((v(out) * i(Vmout)) / (v(ina1) * i(Vmin)))
*plot vr(out) vi(out) vp(out)

alterparam m = 5
reset
*ac lin 50000 10Meg 3000Meg
ac lin 50000 400Meg 500Meg
plot title "L Match Output Impedance" v(out) vi(out)

.endc

.end
