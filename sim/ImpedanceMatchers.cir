*
* This contains small simulations of the iput and output impedance
* matching circuits in the LNA and PA sections.  Modify the if
* statements to get the one you want, make sure to look at the
* graph with the right frequencies!
*
* Also remember that on the output side, the load side of the match
* is looking into the PA/LNA device.  So it's backwards.
*

* Comments above are the exact values from the generation tool.
* Value used are available inductors and capacitors.

* Unless otherwise mentioned, assume all inductors have a Q of around 35
* at 144MHz.  This is a pretty good assumption for the Coilcraft 0603DC
* inductors.

* Unless otherwise mentioned, assume all inductors have a Q of around 55
* at 435MHz.  This is a pretty good assumption for the Coilcraft 0402DC
* inductors.

.SUBCKT PAInImpedance in measure1 measure2 out

* These are the values I measured with the VNA
* +9.87 ohms
Lout in       measure1  3.6n
Rout measure2 out       2.43
* These are the values from the provided S-Parameters.
* -1.04 ohms at 435MHz
*Cout in       measure1  350p
*Rout measure2 out       1.63

.ENDS

.SUBCKT ImpMatchPAIn in out

* TX PA input matcher
* This is what is currently installed
* Q=65, Coilcraft 0603DC
L1     in      a1a     3.3n
Rl1    a1a     0       .13
C1     in      out     22p

* Assuming the input impedance is correct, this would be a better
* match.
*L1     in      a1a     4.3n
*Rl1    a1a     0       .13
*C1     in      out     17p

.ENDS

.SUBCKT PAOutImpedance in measure1 measure2 out

Rsrc in       measure1  4.63
* -.510 ohms
Csrc measure2 out       718p

.ENDS

.SUBCKT ImpMatchPAOut in out

* Inductor on the PA output.
Lpa  in  0 100n

* Trace inductance.  The trace from the PA output to the
* end of the match capacitor is 10mm, .5mm thick coplanar
* with .5mm spacing, 1 oz (.0348mm) thickness. Calculating
* at https://wcalc.sourceforge.net/cgi-bin/coplanar.cgi
* I get .19nH/mm and .2pF/mm, so 1.9nH and 2pF.
Lp1 in a2 1.9n
Cp1 a2 0  2p

* Impedance matching network
* TX PA output matcher
C1	a2	out	18p
* Q=55, CoilCraft 0402DC
L1	out	a3	6.0n
Rl1	a3	0	.30
Cl1	out	0	.037p

.ENDS

.SUBCKT LNAInImpedance in measure1 measure2 out

* -80.8 ohms at 145MHz
Cout in       measure1 13.6p
Rout measure2 out      142.4

.ENDS

.SUBCKT ImpMatchLNAIn in out

* TX LNA input matcher
* Coilcraft 0805CS series has a Q of around 50
L1   in     a1   91n
R1   a1     out  1.67
C1   out    0    6.5p

.ENDS

.SUBCKT LNAOutImpedance in measure1 measure2 out

Rsrc in        measure1  86.6
* -1.88 ohms at 145MHz
Csrc measure2  out       583p

.ENDS

.SUBCKT ImpMatchLNAOut in out

* LNA output inductor
Llna    in      0       470n

* Decoupling cap to remove DC bias
C0      in      in1	1n

* TX LNA output matcher
C1	in1	0	12p
* Coilcraft 0603DC series has a Q of around 35
L1	in	a2	43n
Rl1	a2	out2	1.12
Cl1	in	out2	.186p

* Trace inductance.  The trace from the filter input to the
* end of the match inductor is 7mm, .225mm thick coplanar
* with .5mm spacing, 1 oz (.0348mm) thickness. Calculating
* at https://wcalc.sourceforge.net/cgi-bin/coplanar.cgi
* I get .32nH/mm and .13pF/mm, so 2.2nH and .91pF.
Lt	out2	out	2.2n
Ct	out	0	.91p

.ENDS

.end
