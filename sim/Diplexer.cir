* Diplexer on antenna, single antenna with UHF and VHF split

* Note that the primary purpose of this diplexer is not filtering,
* though it does that, too, just not as much as a normal diplexer.
* The purpose of this is to help filter 435MHz out of the 145MHz input
* to some extent (though there's already a hefty filter on that input)
* and to provide proper impedance matching on all the ports.  It
* doesn't do much to keep 145MHz out of 435MHz, but 145MHz doesn't
* transmit.

*                       input
*                       |   lower freq output
*                       |   |     higher freq output
*                       |   |     |
.SUBCKT Diplexer144x435 in  outlo outhi

.if (1)
* Trap version.  Each branch has a parallel trap tuned to the other
* band, so it looks open at the other band no matter what impedance
* the other port presents (the TX chain is about 9+j81 ohms at 146MHz
* because of L38, and the RX chain is about 1+j12 ohms at 436MHz
* because of C100; with board 2 active these get rotated by the
* inter-board cables).  A series part then resonates each branch at
* its own band.  Put the trap at the common-node end of each branch.

* RX branch: 39nH || 3.4pF trap at ~437MHz, 27pF series to resonate
* at 146MHz.  The 3.4pF includes nothing for parasitics; inductor
* self capacitance and pads add to it, so expect to trim it.
L1a	in	in1a	39n
RL1a	in1a	in1b	0.8
C1	in	in1b	3.4p
C1b	in1b	outlo	27p

L2a	in	in2a	100n
Rl2a	in2a	in2b	1.5
C2	in	in2b	12p
L2b	in2b	in2c	12n
RL2b	in2c	outhi	0.3
.endif

.if (0)
* Narrow bandpass filters to allow 435 and 145 through
L1	in	in1a	220n
Rl1	in1a	in1b	3.36
C1	in1b	outlo	6p

L2	in	in2a	27n
Rl2	in2a	in2b	0.6
C2	in2b	outhi	5p
.endif

.if (0)
* Narrow notch filters to block 435 and 145

L1	in	in1a	220n
Rl1	in1a	outhi	3.36
C1	in	outhi	14p

L2	in	in2a	27n
Rl2	in2a	outlo	0.6
C2	in	outlo	5p
.endif

.if (0)

* Normal diplexer.  This is from
* https://github.com/antonjan/vhf_uhf_diplexer
* It doesn't have good impedance matching on 440MHz, but in
* general it seems to work pretty well.  A lot more than we
* need.

C3	in	in1a	4.7p
L4	in1a	0	15n
C4	in1a	in1b	2.7p
L5	in1b	0	15n
C5	in1b	outhi	4.7p

L1	in	in2a	68n
Rl1	in2a	in2b	0.6
C1	in2b	0	18p
L2	in2b	in2c	100n
Rl2	in2c	in2d	0.6
C2	in2d	0	18p
L3	in2d	in2e	68n
Rl3	in2e	outlo	0.6
.endif

.ends

.include Filters.cir

.param m = 0

* Measure impedance
.if (m == 1)
I1  0  in dc 0 ac 1
Rlo outlo 0 50
Rhi outhi 0 50
.endif

.if (m == 3)
Rin in    0 50
I1  0  outlo dc 0 ac 1
Rhi outhi 0 50
.endif

.if (m == 4)
Rin in    0 50
Rlo outlo 0 50
I1  0  outhi dc 0 ac 1
.endif

* Measure loss
.if (m == 2)
Vin ina 0 dc 0 AC 1 sin(0 1 146MEG 0 0 0)
Rin ina in 50
Rlo outlo 0 50
Rhi outhi 0 50
.endif

* Just the diplexer
X1 in outlo outhi Diplexer144x435

* The diplexer with the filters
*X1 in inlo inhi Diplexer144x435
*X2 inlo outlo Filt144MHzLNAIn
*X3 inhi outhi Filt440MHz

.control
*tran 1ns 102000ns 101000ns
*plot v(in1), v(out)

alterparam m = 1
reset
ac lin 50000 100Meg 500Meg
plot title "Input Impedance" v(in) vi(in)

alterparam m = 3
reset
ac lin 50000 100Meg 500Meg
plot title "Lo Input Impedance" v(outlo) vi(outlo)

alterparam m = 4
reset
ac lin 50000 100Meg 500Meg
plot title "Hi Input Impedance" v(outhi) vi(outhi)

alterparam m = 2
reset
ac lin 50000 100Meg 1000Meg
plot title "Loss" db(2 * v(outlo) / v(ina)) db(2 * v(outhi) / vm(ina))
